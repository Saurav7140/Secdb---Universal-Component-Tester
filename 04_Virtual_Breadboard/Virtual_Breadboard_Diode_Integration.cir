* SECDB Phase 4D - two-polarity diode integration through OPA391/PA0 path
* One physical OPA391 and one TMUX1104 sequentially read terminals A and B.
* The duplicated OPA instances below represent those two sequential sense states.

.include OPA391_TI_Model\OPAx391.LIB
.lib C:\Users\Saurav\AppData\Local\LTspice\lib\cmp\standard.dio

.param RGPIO=50
.param RLIMIT=1.001k
.param RLEG=RGPIO+RLIMIT
.param RON_SENSE=9.5

VCC VCC 0 3.3
VDRIVE_A DRIVE_A 0 3.3
VDRIVE_B DRIVE_B 0 0

* 1N4148: physical anode at terminal A, cathode at terminal B.
RSI_A DRIVE_A SI_A {RLEG}
DSI SI_A SI_B 1N4148
RSI_B SI_B DRIVE_B {RLEG}
RSI_SWA SI_A SI_IN_A {RON_SENSE}
XSI_A SI_IN_A SI_OUT_A VCC 0 SI_OUT_A OPAx391
RSI_ISOA SI_OUT_A SI_ADC_A 100
CSI_ADCA SI_ADC_A 0 7p
RSI_SWB SI_B SI_IN_B {RON_SENSE}
XSI_B SI_IN_B SI_OUT_B VCC 0 SI_OUT_B OPAx391
RSI_ISOB SI_OUT_B SI_ADC_B 100
CSI_ADCB SI_ADC_B 0 7p

* 1N5819 Schottky comparison.
RSCH_A DRIVE_A SCH_A {RLEG}
DSCH SCH_A SCH_B 1N5819
RSCH_B SCH_B DRIVE_B {RLEG}
RSCH_SWA SCH_A SCH_IN_A {RON_SENSE}
XSCH_A SCH_IN_A SCH_OUT_A VCC 0 SCH_OUT_A OPAx391
RSCH_ISOA SCH_OUT_A SCH_ADC_A 100
CSCH_ADCA SCH_ADC_A 0 7p
RSCH_SWB SCH_B SCH_IN_B {RON_SENSE}
XSCH_B SCH_IN_B SCH_OUT_B VCC 0 SCH_OUT_B OPAx391
RSCH_ISOB SCH_OUT_B SCH_ADC_B 100
CSCH_ADCB SCH_ADC_B 0 7p

* Illustrative red LED comparison; it is not a universal LED specification.
RLED_A DRIVE_A LED_A {RLEG}
DLED LED_A LED_B RED_LED
RLED_B LED_B DRIVE_B {RLEG}
RLED_SWA LED_A LED_IN_A {RON_SENSE}
XLED_A LED_IN_A LED_OUT_A VCC 0 LED_OUT_A OPAx391
RLED_ISOA LED_OUT_A LED_ADC_A 100
CLED_ADCA LED_ADC_A 0 7p
RLED_SWB LED_B LED_IN_B {RON_SENSE}
XLED_B LED_IN_B LED_OUT_B VCC 0 LED_OUT_B OPAx391
RLED_ISOB LED_OUT_B LED_ADC_B 100
CLED_ADCB LED_ADC_B 0 7p
.model RED_LED D(Is=1e-20 N=2 Rs=10 Eg=1.8)

.step temp list -10 25 60
.tran 0 10u 0 100n

.meas TRAN VSI_A FIND V(SI_ADC_A) AT=10u
.meas TRAN VSI_B FIND V(SI_ADC_B) AT=10u
.meas TRAN VTEST_SI PARAM V(SI_ADC_A)-V(SI_ADC_B)
.meas TRAN ITEST_SI PARAM abs(I(RSI_A))
.meas TRAN CODE_SI_A PARAM V(SI_ADC_A)*4095/3.3
.meas TRAN CODE_SI_B PARAM V(SI_ADC_B)*4095/3.3

.meas TRAN VSCH_A FIND V(SCH_ADC_A) AT=10u
.meas TRAN VSCH_B FIND V(SCH_ADC_B) AT=10u
.meas TRAN VTEST_SCH PARAM V(SCH_ADC_A)-V(SCH_ADC_B)
.meas TRAN ITEST_SCH PARAM abs(I(RSCH_A))

.meas TRAN VLED_A FIND V(LED_ADC_A) AT=10u
.meas TRAN VLED_B FIND V(LED_ADC_B) AT=10u
.meas TRAN VTEST_LED PARAM V(LED_ADC_A)-V(LED_ADC_B)
.meas TRAN ITEST_LED PARAM abs(I(RLED_A))
.end
