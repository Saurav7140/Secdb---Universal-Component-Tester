* SECDB Phase 4E - known-pinout NPN/PNP integration through shared OPA391/PA0
* Duplicated OPA391 instances represent sequential E, B, C TMUX sense states.

.include OPA391_TI_Model\OPAx391.LIB

.param BETA=100
.param REMIT=100+50
.param RBASE=1.001Meg+50
.param RCOL=1.001k+50
.param RON_SENSE=9.5
.param EADC=3.973m

VCC VCC 0 3.3

* NPN mode: emitter drive low, base and collector drives high.
RN_E N_E 0 {REMIT}
RN_B VCC N_B {RBASE}
RN_C VCC N_C {RCOL}
QN N_C N_B N_E NTEST
.model NTEST NPN(Is=1e-14 Bf={BETA} Vaf=100)

RN_SE N_E N_E_IN {RON_SENSE}
XN_E N_E_IN N_E_OUT VCC 0 N_E_OUT OPAx391
RN_EISO N_E_OUT N_E_ADC 100
CN_EADC N_E_ADC 0 7p
RN_SB N_B N_B_IN {RON_SENSE}
XN_B N_B_IN N_B_OUT VCC 0 N_B_OUT OPAx391
RN_BISO N_B_OUT N_B_ADC 100
CN_BADC N_B_ADC 0 7p
RN_SC N_C N_C_IN {RON_SENSE}
XN_C N_C_IN N_C_OUT VCC 0 N_C_OUT OPAx391
RN_CISO N_C_OUT N_C_ADC 100
CN_CADC N_C_ADC 0 7p

* PNP mode: emitter drive high, base and collector drives low.
RP_E VCC P_E {REMIT}
RP_B P_B 0 {RBASE}
RP_C P_C 0 {RCOL}
QP P_C P_B P_E PTEST
.model PTEST PNP(Is=1e-14 Bf={BETA} Vaf=100)

RP_SE P_E P_E_IN {RON_SENSE}
XP_E P_E_IN P_E_OUT VCC 0 P_E_OUT OPAx391
RP_EISO P_E_OUT P_E_ADC 100
CP_EADC P_E_ADC 0 7p
RP_SB P_B P_B_IN {RON_SENSE}
XP_B P_B_IN P_B_OUT VCC 0 P_B_OUT OPAx391
RP_BISO P_B_OUT P_B_ADC 100
CP_BADC P_B_ADC 0 7p
RP_SC P_C P_C_IN {RON_SENSE}
XP_C P_C_IN P_C_OUT VCC 0 P_C_OUT OPAx391
RP_CISO P_C_OUT P_C_ADC 100
CP_CADC P_C_ADC 0 7p

.step param BETA list 20 30 50 100 200 300 500
.temp 25
.tran 0 10u 0 100n
.save V(N_E_ADC) V(N_B_ADC) V(N_C_ADC) V(P_E_ADC) V(P_B_ADC) V(P_C_ADC)

.meas TRAN N_VE FIND V(N_E_ADC) AT=10u
.meas TRAN N_VB FIND V(N_B_ADC) AT=10u
.meas TRAN N_VC FIND V(N_C_ADC) AT=10u
.meas TRAN N_VBE PARAM V(N_B_ADC)-V(N_E_ADC)
.meas TRAN N_VCE PARAM V(N_C_ADC)-V(N_E_ADC)
.meas TRAN N_VCB PARAM V(N_C_ADC)-V(N_B_ADC)
.meas TRAN N_IB PARAM (3.3-V(N_B_ADC))/RBASE
.meas TRAN N_IC PARAM (3.3-V(N_C_ADC))/RCOL
.meas TRAN N_HFE_CAL PARAM ((3.3-V(N_C_ADC))/RCOL)/((3.3-V(N_B_ADC))/RBASE)
.meas TRAN N_HFE_LOW PARAM ((3.3-(V(N_C_ADC)+EADC))/RCOL)/((3.3-(V(N_B_ADC)-EADC))/RBASE)
.meas TRAN N_HFE_HIGH PARAM ((3.3-(V(N_C_ADC)-EADC))/RCOL)/((3.3-(V(N_B_ADC)+EADC))/RBASE)

.meas TRAN P_VE FIND V(P_E_ADC) AT=10u
.meas TRAN P_VB FIND V(P_B_ADC) AT=10u
.meas TRAN P_VC FIND V(P_C_ADC) AT=10u
.meas TRAN P_VEB PARAM V(P_E_ADC)-V(P_B_ADC)
.meas TRAN P_VEC PARAM V(P_E_ADC)-V(P_C_ADC)
.meas TRAN P_VBC PARAM V(P_B_ADC)-V(P_C_ADC)
.meas TRAN P_IB PARAM V(P_B_ADC)/RBASE
.meas TRAN P_IC PARAM V(P_C_ADC)/RCOL
.meas TRAN P_HFE_CAL PARAM (V(P_C_ADC)/RCOL)/(V(P_B_ADC)/RBASE)
.meas TRAN P_HFE_LOW PARAM ((V(P_C_ADC)-EADC)/RCOL)/((V(P_B_ADC)+EADC)/RBASE)
.meas TRAN P_HFE_HIGH PARAM ((V(P_C_ADC)+EADC)/RCOL)/((V(P_B_ADC)-EADC)/RBASE)
.end
