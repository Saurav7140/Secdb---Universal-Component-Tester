* SECDB Phase 4E - known-pinout BJT real-model, fault, and base-off checks
* Behavioral readback models sequential E/B/C sensing through TMUX + OPA391 + PA0.

.lib C:\Users\Saurav\AppData\Local\LTspice\lib\cmp\standard.bjt
.param REMIT=150
.param RBASE=1.00105Meg
.param RCOL=1.051k

VCC VCC 0 3.3

.subckt ADCREAD IN ADC
RSW IN SENSE 9.5
BUNIT BUFFER 0 V=V(SENSE)
RISO BUFFER ADC 100
CADC ADC 0 7p
.ends ADCREAD

* Healthy NPN and PNP reference circuits.
R_OK_E E_OK 0 {REMIT}
R_OK_B VCC B_OK {RBASE}
R_OK_C VCC C_OK {RCOL}
Q_OK C_OK B_OK E_OK 2N3904
XE_OK E_OK E_OK_ADC ADCREAD
XB_OK B_OK B_OK_ADC ADCREAD
XC_OK C_OK C_OK_ADC ADCREAD

RP_OK_E VCC EP_OK {REMIT}
RP_OK_B BP_OK 0 {RBASE}
RP_OK_C CP_OK 0 {RCOL}
QP_OK CP_OK BP_OK EP_OK 2N3906
XEP_OK EP_OK EP_OK_ADC ADCREAD
XBP_OK BP_OK BP_OK_ADC ADCREAD
XCP_OK CP_OK CP_OK_ADC ADCREAD

* Open base: external socket base is separated from the transistor by 1 Tohm.
R_OB_E E_OB 0 {REMIT}
R_OB_B VCC B_OB {RBASE}
R_OB_OPEN B_OB B_OB_INT 1T
R_OB_C VCC C_OB {RCOL}
Q_OB C_OB B_OB_INT E_OB 2N3904
XE_OB E_OB E_OB_ADC ADCREAD
XB_OB B_OB B_OB_ADC ADCREAD
XC_OB C_OB C_OB_ADC ADCREAD

* Open collector: base junction responds, but collector pin is separated.
R_OC_E E_OC 0 {REMIT}
R_OC_B VCC B_OC {RBASE}
R_OC_C VCC C_OC {RCOL}
R_OC_OPEN C_OC C_OC_INT 1T
Q_OC C_OC_INT B_OC E_OC 2N3904
XE_OC E_OC E_OC_ADC ADCREAD
XB_OC B_OC B_OC_ADC ADCREAD
XC_OC C_OC C_OC_ADC ADCREAD

* C-E, B-E, and B-C shorts.
R_CES_E E_CES 0 {REMIT}
R_CES_B VCC B_CES {RBASE}
R_CES_C VCC C_CES {RCOL}
Q_CES C_CES B_CES E_CES 2N3904
R_CE_SHORT C_CES E_CES 10m
XE_CES E_CES E_CES_ADC ADCREAD
XB_CES B_CES B_CES_ADC ADCREAD
XC_CES C_CES C_CES_ADC ADCREAD

R_BES_E E_BES 0 {REMIT}
R_BES_B VCC B_BES {RBASE}
R_BES_C VCC C_BES {RCOL}
Q_BES C_BES B_BES E_BES 2N3904
R_BE_SHORT B_BES E_BES 10m
XE_BES E_BES E_BES_ADC ADCREAD
XB_BES B_BES B_BES_ADC ADCREAD
XC_BES C_BES C_BES_ADC ADCREAD

R_BCS_E E_BCS 0 {REMIT}
R_BCS_B VCC B_BCS {RBASE}
R_BCS_C VCC C_BCS {RCOL}
Q_BCS C_BCS B_BCS E_BCS 2N3904
R_BC_SHORT B_BCS C_BCS 10m
XE_BCS E_BCS E_BCS_ADC ADCREAD
XB_BCS B_BCS B_BCS_ADC ADCREAD
XC_BCS C_BCS C_BCS_ADC ADCREAD

* Deliberate excessive base drive demonstrates invalid saturation.
R_SAT_E E_SAT 0 {REMIT}
R_SAT_B VCC B_SAT 10.05k
R_SAT_C VCC C_SAT {RCOL}
Q_SAT C_SAT B_SAT E_SAT 2N3904
XE_SAT E_SAT E_SAT_ADC ADCREAD
XB_SAT B_SAT B_SAT_ADC ADCREAD
XC_SAT C_SAT C_SAT_ADC ADCREAD

* Mandatory base-off confirmation: healthy transistor versus physical C-E short.
R_OFF_E E_OFF 0 {REMIT}
R_OFF_B B_OFF 0 {RBASE}
R_OFF_C VCC C_OFF {RCOL}
Q_OFF C_OFF B_OFF E_OFF 2N3904
XE_OFF E_OFF E_OFF_ADC ADCREAD
XB_OFF B_OFF B_OFF_ADC ADCREAD
XC_OFF C_OFF C_OFF_ADC ADCREAD

R_OFFS_E E_OFFS 0 {REMIT}
R_OFFS_B B_OFFS 0 {RBASE}
R_OFFS_C VCC C_OFFS {RCOL}
Q_OFFS C_OFFS B_OFFS E_OFFS 2N3904
R_OFF_CE_SHORT C_OFFS E_OFFS 10m
XE_OFFS E_OFFS E_OFFS_ADC ADCREAD
XB_OFFS B_OFFS B_OFFS_ADC ADCREAD
XC_OFFS C_OFFS C_OFFS_ADC ADCREAD

.step temp list -10 25 60
.tran 0 10u 0 100n

.meas TRAN OK_VBE PARAM V(B_OK_ADC)-V(E_OK_ADC)
.meas TRAN OK_VCE PARAM V(C_OK_ADC)-V(E_OK_ADC)
.meas TRAN OK_VCB PARAM V(C_OK_ADC)-V(B_OK_ADC)
.meas TRAN OK_HFE PARAM ((3.3-V(C_OK_ADC))/RCOL)/((3.3-V(B_OK_ADC))/RBASE)
.meas TRAN P_OK_VEB PARAM V(EP_OK_ADC)-V(BP_OK_ADC)
.meas TRAN P_OK_VEC PARAM V(EP_OK_ADC)-V(CP_OK_ADC)
.meas TRAN P_OK_VBC PARAM V(BP_OK_ADC)-V(CP_OK_ADC)
.meas TRAN P_OK_HFE PARAM (V(CP_OK_ADC)/RCOL)/(V(BP_OK_ADC)/RBASE)

.meas TRAN OB_VBE PARAM V(B_OB_ADC)-V(E_OB_ADC)
.meas TRAN OB_IC PARAM (3.3-V(C_OB_ADC))/RCOL
.meas TRAN OC_VBE PARAM V(B_OC_ADC)-V(E_OC_ADC)
.meas TRAN OC_IC PARAM (3.3-V(C_OC_ADC))/RCOL
.meas TRAN CES_VBE PARAM V(B_CES_ADC)-V(E_CES_ADC)
.meas TRAN CES_VCE PARAM V(C_CES_ADC)-V(E_CES_ADC)
.meas TRAN CES_IC PARAM (3.3-V(C_CES_ADC))/RCOL
.meas TRAN BES_VBE PARAM V(B_BES_ADC)-V(E_BES_ADC)
.meas TRAN BES_IC PARAM (3.3-V(C_BES_ADC))/RCOL
.meas TRAN BCS_VBE PARAM V(B_BCS_ADC)-V(E_BCS_ADC)
.meas TRAN BCS_VCE PARAM V(C_BCS_ADC)-V(E_BCS_ADC)
.meas TRAN BCS_VCB PARAM V(C_BCS_ADC)-V(B_BCS_ADC)
.meas TRAN SAT_VBE PARAM V(B_SAT_ADC)-V(E_SAT_ADC)
.meas TRAN SAT_VCE PARAM V(C_SAT_ADC)-V(E_SAT_ADC)
.meas TRAN SAT_VCB PARAM V(C_SAT_ADC)-V(B_SAT_ADC)
.meas TRAN SAT_RATIO PARAM ((3.3-V(C_SAT_ADC))/RCOL)/((3.3-V(B_SAT_ADC))/10.05k)
.meas TRAN OFF_HEALTHY_VCE PARAM V(C_OFF_ADC)-V(E_OFF_ADC)
.meas TRAN OFF_HEALTHY_IC PARAM (3.3-V(C_OFF_ADC))/RCOL
.meas TRAN OFF_SHORT_VCE PARAM V(C_OFFS_ADC)-V(E_OFFS_ADC)
.meas TRAN OFF_SHORT_IC PARAM (3.3-V(C_OFFS_ADC))/RCOL
.end
