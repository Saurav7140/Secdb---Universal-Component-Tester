* SECDB Phase 4D - two-polarity diode open/short/leakage fault signatures
* Behavioral unity buffers model sequential terminal reads through the same ADC.

.lib C:\Users\Saurav\AppData\Local\LTspice\lib\cmp\standard.dio

.param POL=0
.param RLEG=1.001k+50
.param RON_SENSE=9.5

VDRIVE_A DRIVE_A 0 {if(POL<0.5,3.3,0)}
VDRIVE_B DRIVE_B 0 {if(POL<0.5,0,3.3)}

* Healthy 1N4148 fixed with anode at A and cathode at B.
RHEALTHY_A DRIVE_A HEALTHY_A {RLEG}
DHEALTHY HEALTHY_A HEALTHY_B 1N4148
RHEALTHY_B HEALTHY_B DRIVE_B {RLEG}
RHEALTHY_SWA HEALTHY_A HEALTHY_IN_A {RON_SENSE}
BHEALTHY_A HEALTHY_OUT_A 0 V=V(HEALTHY_IN_A)
RHEALTHY_ISOA HEALTHY_OUT_A HEALTHY_ADC_A 100
RHEALTHY_SWB HEALTHY_B HEALTHY_IN_B {RON_SENSE}
BHEALTHY_B HEALTHY_OUT_B 0 V=V(HEALTHY_IN_B)
RHEALTHY_ISOB HEALTHY_OUT_B HEALTHY_ADC_B 100

* 1 Gohm open reference.
ROPEN_A DRIVE_A OPEN_A {RLEG}
ROPEN_DUT OPEN_A OPEN_B 1G
ROPEN_B OPEN_B DRIVE_B {RLEG}
ROPEN_SWA OPEN_A OPEN_IN_A {RON_SENSE}
BOPEN_A OPEN_OUT_A 0 V=V(OPEN_IN_A)
ROPEN_ISOA OPEN_OUT_A OPEN_ADC_A 100
IOPEN_ADCA OPEN_ADC_A 0 1u
ROPEN_SWB OPEN_B OPEN_IN_B {RON_SENSE}
BOPEN_B OPEN_OUT_B 0 V=V(OPEN_IN_B)
ROPEN_ISOB OPEN_OUT_B OPEN_ADC_B 100
IOPEN_ADCB 0 OPEN_ADC_B 1u

* 10 milliohm short reference.
RSHORT_A DRIVE_A SHORT_A {RLEG}
RSHORT_DUT SHORT_A SHORT_B 10m
RSHORT_B SHORT_B DRIVE_B {RLEG}
RSHORT_SWA SHORT_A SHORT_IN_A {RON_SENSE}
BSHORT_A SHORT_OUT_A 0 V=V(SHORT_IN_A)
RSHORT_ISOA SHORT_OUT_A SHORT_ADC_A 100
ISHORT_ADCA SHORT_ADC_A 0 1u
RSHORT_SWB SHORT_B SHORT_IN_B {RON_SENSE}
BSHORT_B SHORT_OUT_B 0 V=V(SHORT_IN_B)
RSHORT_ISOB SHORT_OUT_B SHORT_ADC_B 100
ISHORT_ADCB 0 SHORT_ADC_B 1u

* Resistive leakage references.
R100K_A DRIVE_A L100_A {RLEG}
R100K_DUT L100_A L100_B 100k
R100K_B L100_B DRIVE_B {RLEG}
R100K_SWA L100_A L100_IN_A {RON_SENSE}
B100K_A L100_OUT_A 0 V=V(L100_IN_A)
R100K_ISOA L100_OUT_A L100_ADC_A 100
R100K_SWB L100_B L100_IN_B {RON_SENSE}
B100K_B L100_OUT_B 0 V=V(L100_IN_B)
R100K_ISOB L100_OUT_B L100_ADC_B 100

R10K_A DRIVE_A L10_A {RLEG}
R10K_DUT L10_A L10_B 10k
R10K_B L10_B DRIVE_B {RLEG}
R10K_SWA L10_A L10_IN_A {RON_SENSE}
B10K_A L10_OUT_A 0 V=V(L10_IN_A)
R10K_ISOA L10_OUT_A L10_ADC_A 100
R10K_SWB L10_B L10_IN_B {RON_SENSE}
B10K_B L10_OUT_B 0 V=V(L10_IN_B)
R10K_ISOB L10_OUT_B L10_ADC_B 100

.step param POL list 0 1
.tran 0 10u 0 100n

.meas TRAN VOPEN PARAM if(POL<0.5,V(OPEN_ADC_A)-V(OPEN_ADC_B),V(OPEN_ADC_B)-V(OPEN_ADC_A))
.meas TRAN VHEALTHY PARAM if(POL<0.5,V(HEALTHY_ADC_A)-V(HEALTHY_ADC_B),V(HEALTHY_ADC_B)-V(HEALTHY_ADC_A))
.meas TRAN VSHORT PARAM if(POL<0.5,V(SHORT_ADC_A)-V(SHORT_ADC_B),V(SHORT_ADC_B)-V(SHORT_ADC_A))
.meas TRAN ISHORT PARAM abs(I(RSHORT_A))
.meas TRAN VLEAK_100K PARAM if(POL<0.5,V(L100_ADC_A)-V(L100_ADC_B),V(L100_ADC_B)-V(L100_ADC_A))
.meas TRAN VLEAK_10K PARAM if(POL<0.5,V(L10_ADC_A)-V(L10_ADC_B),V(L10_ADC_B)-V(L10_ADC_A))
.meas TRAN CODE_OPEN_HIGH PARAM max(V(OPEN_ADC_A),V(OPEN_ADC_B))*4095/3.3
.meas TRAN CODE_OPEN_LOW PARAM min(V(OPEN_ADC_A),V(OPEN_ADC_B))*4095/3.3
.end
