* SECDB Phase 4A - TI OPAx391 vendor macro-model verification in LTspice
* Vendor model: TI OPAx391 PSpice Model Rev. B, model version Final 1.3.

.include OPA391_TI_Model\OPAx391.LIB

VCC VCC 0 3.3
R1 VCC TAP_2V2 10k
R2 TAP_2V2 TAP_1V1 10k
R3 TAP_1V1 0 10k

* OPAx391 subcircuit pin order: IN+ IN- VCC VEE OUT
XU_1V1 TAP_1V1 OUT_1V1 VCC 0 OUT_1V1 OPAx391
RISO_1V1 OUT_1V1 ADC_1V1 100
CLOAD_1V1 ADC_1V1 0 7p
IADC_1V1 ADC_1V1 0 1u

XU_2V2 TAP_2V2 OUT_2V2 VCC 0 OUT_2V2 OPAx391
RISO_2V2 OUT_2V2 ADC_2V2 100
CLOAD_2V2 ADC_2V2 0 7p
IADC_2V2 0 ADC_2V2 1u

* Dynamic tap-change equivalent: input changes from 1.1V to 2.2V at 100us.
VSTEP IN_STEP 0 PULSE(1.1 2.2 100u 1n 1n 100u 250u)
XU_STEP IN_STEP OUT_STEP VCC 0 OUT_STEP OPAx391
RISO_STEP OUT_STEP ADC_STEP 100
CLOAD_STEP ADC_STEP 0 7p
IADC_STEP ADC_STEP 0 1u

.temp 25
.op
.tran 0 220u 0 20n
.meas TRAN LADDER_1V1 FIND V(TAP_1V1) AT=50u
.meas TRAN VOUT_1V1 FIND V(OUT_1V1) AT=50u
.meas TRAN VADC_1V1 FIND V(ADC_1V1) AT=50u
.meas TRAN ERR_1V1_MV PARAM (V(ADC_1V1)-1.1)*1000
.meas TRAN CODE_1V1 PARAM V(ADC_1V1)*4095/3.3
.meas TRAN LADDER_2V2 FIND V(TAP_2V2) AT=50u
.meas TRAN VOUT_2V2 FIND V(OUT_2V2) AT=50u
.meas TRAN VADC_2V2 FIND V(ADC_2V2) AT=50u
.meas TRAN ERR_2V2_MV PARAM (V(ADC_2V2)-2.2)*1000
.meas TRAN CODE_2V2 PARAM V(ADC_2V2)*4095/3.3
.meas TRAN TSET_RISE_1MV TRIG V(IN_STEP) VAL=1.65 RISE=1 TARG V(ADC_STEP) VAL=2.199 RISE=1
.end
