* SECDB Phase 3 - STM32 input leakage risk and OPA391 buffer check
VCC VCC 0 3.3

* 1Mohm test with calibrated 100109.5 ohm reference path.
* Unbuffered branches use the STM32F401 maximum +/-1uA I/O leakage.
RPATH_UP VCC ADC_UP 100109.5
RX_UP ADC_UP 0 1Meg
ILEAK_UP VCC ADC_UP 1u

RPATH_DN VCC ADC_DN 100109.5
RX_DN ADC_DN 0 1Meg
ILEAK_DN ADC_DN VCC 1u

* Buffered positive-error branch. The divider sees only OPA391 input bias.
RPATH_BP VCC SENSE_BP 100109.5
RX_BP SENSE_BP 0 1Meg
IBIAS_BP VCC SENSE_BP 5p
EAMP_BP NBUF_BP 0 VALUE={V(SENSE_BP)+750u}
ROUT_BP NBUF_BP ADC_BP 10
IADC_BP VCC ADC_BP 1u

* Buffered negative-error branch.
RPATH_BM VCC SENSE_BM 100109.5
RX_BM SENSE_BM 0 1Meg
IBIAS_BM SENSE_BM VCC 5p
EAMP_BM NBUF_BM 0 VALUE={V(SENSE_BM)-750u}
ROUT_BM NBUF_BM ADC_BM 10
IADC_BM ADC_BM VCC 1u

.op
.meas OP V_UNBUFFERED_UP FIND V(ADC_UP)
.meas OP R_UNBUFFERED_UP PARAM 100109.5*V(ADC_UP)/(3.3-V(ADC_UP))
.meas OP V_UNBUFFERED_DN FIND V(ADC_DN)
.meas OP R_UNBUFFERED_DN PARAM 100109.5*V(ADC_DN)/(3.3-V(ADC_DN))

.meas OP V_BUFFERED_UP FIND V(ADC_BP)
.meas OP R_BUFFERED_UP PARAM 100109.5*V(ADC_BP)/(3.3-V(ADC_BP))
.meas OP V_BUFFERED_DN FIND V(ADC_BM)
.meas OP R_BUFFERED_DN PARAM 100109.5*V(ADC_BM)/(3.3-V(ADC_BM))
.end
