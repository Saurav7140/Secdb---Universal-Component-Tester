* SECDB Phase 3 - effect of analog-switch on-resistance on resistor ranges
VCC VCC 0 3.3

* 1k range, tested at mid-scale RX=1k
RREF_1K_10 VCC N_1K_10 1k
RON_1K_10 N_1K_10 ADC_1K_10 10
RX_1K_10 ADC_1K_10 0 1k

RREF_1K_50 VCC N_1K_50 1k
RON_1K_50 N_1K_50 ADC_1K_50 50
RX_1K_50 ADC_1K_50 0 1k

* 10k range, tested at mid-scale RX=10k
RREF_10K_10 VCC N_10K_10 10k
RON_10K_10 N_10K_10 ADC_10K_10 10
RX_10K_10 ADC_10K_10 0 10k

RREF_10K_50 VCC N_10K_50 10k
RON_10K_50 N_10K_50 ADC_10K_50 50
RX_10K_50 ADC_10K_50 0 10k

* 100k range, tested at mid-scale RX=100k
RREF_100K_10 VCC N_100K_10 100k
RON_100K_10 N_100K_10 ADC_100K_10 10
RX_100K_10 ADC_100K_10 0 100k

RREF_100K_50 VCC N_100K_50 100k
RON_100K_50 N_100K_50 ADC_100K_50 50
RX_100K_50 ADC_100K_50 0 100k

.op
.meas OP V_1K_RON10 FIND V(ADC_1K_10)
.meas OP RCALC_1K_RON10 PARAM 1k*V(ADC_1K_10)/(3.3-V(ADC_1K_10))
.meas OP V_1K_RON50 FIND V(ADC_1K_50)
.meas OP RCALC_1K_RON50 PARAM 1k*V(ADC_1K_50)/(3.3-V(ADC_1K_50))

.meas OP V_10K_RON10 FIND V(ADC_10K_10)
.meas OP RCALC_10K_RON10 PARAM 10k*V(ADC_10K_10)/(3.3-V(ADC_10K_10))
.meas OP V_10K_RON50 FIND V(ADC_10K_50)
.meas OP RCALC_10K_RON50 PARAM 10k*V(ADC_10K_50)/(3.3-V(ADC_10K_50))

.meas OP V_100K_RON10 FIND V(ADC_100K_10)
.meas OP RCALC_100K_RON10 PARAM 100k*V(ADC_100K_10)/(3.3-V(ADC_100K_10))
.meas OP V_100K_RON50 FIND V(ADC_100K_50)
.meas OP RCALC_100K_RON50 PARAM 100k*V(ADC_100K_50)/(3.3-V(ADC_100K_50))
.end
