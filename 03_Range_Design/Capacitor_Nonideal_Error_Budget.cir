* SECDB Phase 3 - capacitor timing and non-ideal error budget
* RG=50 ohm GPIO output resistance, RCH=10.01k (+0.1%), CPAR=50pF.
VSTEP VCC 0 PULSE(0 3.3 0 1n 1n 10s 20s)

RG100N VCC G100N 50
R100N G100N N100N 10.01k
C100N N100N 0 100n
CP100N N100N 0 50p

RG1U VCC G1U 50
R1U G1U N1U 10.01k
C1U N1U 0 1u
CP1U N1U 0 50p

RG10U VCC G10U 50
R10U G10U N10U 10.01k
C10U N10U 0 10u
CP10U N10U 0 50p

RG100U VCC G100U 50
R100U G100U N100U 10.01k
C100U N100U 0 100u
CP100U N100U 0 50p

* 100uF leakage references.
RG_L1M VCC G_L1M 50
R_L1M G_L1M N_L1M 10.01k
C_L1M N_L1M 0 100u
RLEAK_1M N_L1M 0 1Meg

RG_L100K VCC G_L100K 50
R_L100K G_L100K N_L100K 10.01k
C_L100K N_L100K 0 100u
RLEAK_100K N_L100K 0 100k

RG_L15K VCC G_L15K 50
R_L15K G_L15K N_L15K 10.01k
C_L15K N_L15K 0 100u
RLEAK_15K N_L15K 0 15k

* Deliberately exaggerated 100-ohm ESR reference.
RG_ESR VCC G_ESR 50
R_ESR G_ESR N_ESR 10.01k
RESR N_ESR NCAP_ESR 100
C_ESR NCAP_ESR 0 100u

* Fault references.
RG_OPEN VCC G_OPEN 50
R_OPEN G_OPEN N_OPEN 10.01k

RG_SHORT VCC G_SHORT 50
R_SHORT G_SHORT N_SHORT 10.01k
RFAULT_SHORT N_SHORT 0 10m

.options plotwinsize=0 reltol=1e-6
.tran 0 5s

* Nominal threshold is ADC code 2589; +/-4 LSB maps to codes 2585/2593.
.meas TRAN T100N_EARLY WHEN V(N100N)=2.083150183 RISE=1
.meas TRAN T100N_NOM WHEN V(N100N)=2.086373626 RISE=1
.meas TRAN T100N_LATE WHEN V(N100N)=2.089597070 RISE=1
.meas TRAN C100N_CALC PARAM T100N_NOM/10k

.meas TRAN T1U_EARLY WHEN V(N1U)=2.083150183 RISE=1
.meas TRAN T1U_NOM WHEN V(N1U)=2.086373626 RISE=1
.meas TRAN T1U_LATE WHEN V(N1U)=2.089597070 RISE=1
.meas TRAN C1U_CALC PARAM T1U_NOM/10k

.meas TRAN T10U_EARLY WHEN V(N10U)=2.083150183 RISE=1
.meas TRAN T10U_NOM WHEN V(N10U)=2.086373626 RISE=1
.meas TRAN T10U_LATE WHEN V(N10U)=2.089597070 RISE=1
.meas TRAN C10U_CALC PARAM T10U_NOM/10k

.meas TRAN T100U_EARLY WHEN V(N100U)=2.083150183 RISE=1
.meas TRAN T100U_NOM WHEN V(N100U)=2.086373626 RISE=1
.meas TRAN T100U_LATE WHEN V(N100U)=2.089597070 RISE=1
.meas TRAN C100U_CALC PARAM T100U_NOM/10k

.meas TRAN T100U_LEAK1M WHEN V(N_L1M)=2.086373626 RISE=1
.meas TRAN T100U_LEAK100K WHEN V(N_L100K)=2.086373626 RISE=1
.meas TRAN V_LEAK15K_5S FIND V(N_L15K) AT=5s
.meas TRAN T100U_ESR100 WHEN V(N_ESR)=2.086373626 RISE=1

.meas TRAN V_OPEN_10US FIND V(N_OPEN) AT=10u
.meas TRAN V_SHORT_5S FIND V(N_SHORT) AT=5s
.end
