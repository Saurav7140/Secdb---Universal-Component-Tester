* SECDB Phase 5B - resistor mode through shared U_SRC TMUX1104,
* U_SENSE TMUX1108, one OPA391 and PA0.
* Inactive sense channels are represented by off resistance/capacitance.

.include OPA391_TI_Model\OPAx391.LIB

.param RX=1k
.param RSEL=if(RX<3.16227766k,1k,if(RX<31.6227766k,10k,100k))
.param RREF_ACT=RSEL*1.001
.param RPATH=RREF_ACT+9.5
.param EADC=3.973m

VCC VCC 0 3.3

* Selected U_SRC path and R/C socket.
RREF VCC REF_OUT {RREF_ACT}
RSRC_ON REF_OUT RC_SENSE 9.5
RX_DUT RC_SENSE 0 {RX}

* Other U_SRC channels remain physically present but disabled.
RSRC_OFF1 VCC RC_SENSE 1T
RSRC_OFF2 VCC RC_SENSE 1T
RSRC_OFF3 0 RC_SENSE 1T

* Selected U_SENSE channel. 100p includes its 65p typical on-capacitance
* plus socket, trace, and buffer-input allocation.
RSENSE_ON RC_SENSE SENSE_IN 9.5
CSENSE_IN SENSE_IN 0 100p
ROFF_DIO_A DUMMY_DA SENSE_IN 1T
ROFF_DIO_B DUMMY_DB SENSE_IN 1T
ROFF_BJT_E DUMMY_BE SENSE_IN 1T
ROFF_BJT_B DUMMY_BB SENSE_IN 1T
ROFF_BJT_C DUMMY_BC SENSE_IN 1T
ROFF_CAL1 DUMMY_C1 SENSE_IN 1T
ROFF_CAL2 DUMMY_C2 SENSE_IN 1T
RDUMMY_DA DUMMY_DA 0 1T
RDUMMY_DB DUMMY_DB 0 1T
RDUMMY_BE DUMMY_BE 0 1T
RDUMMY_BB DUMMY_BB 0 1T
RDUMMY_BC DUMMY_BC 0 1T
RDUMMY_C1 DUMMY_C1 0 1T
RDUMMY_C2 DUMMY_C2 0 1T

XU SENSE_IN OUT VCC 0 OUT OPAx391
RISO OUT ADC 100
CADC ADC 0 7p

* Worst-low and worst-high replicas include conservative total mux leakage,
* output leakage, and the established per-reading ADC/buffer allocation.
RREF_L VCC REF_L {RREF_ACT}
RSRC_L REF_L RC_L 9.5
RX_L RC_L 0 {RX}
RSENSE_L RC_L SIN_L 9.5
CSIN_L SIN_L 0 100p
IMUX_L SIN_L 0 2n
XUL SIN_L OUT_L VCC 0 OUT_L OPAx391
RISO_L OUT_L ADC_L 100
CADC_L ADC_L 0 7p
IADC_L ADC_L 0 1u

RREF_H VCC REF_H {RREF_ACT}
RSRC_H REF_H RC_H 9.5
RX_H RC_H 0 {RX}
RSENSE_H RC_H SIN_H 9.5
CSIN_H SIN_H 0 100p
IMUX_H 0 SIN_H 2n
XUH SIN_H OUT_H VCC 0 OUT_H OPAx391
RISO_H OUT_H ADC_H 100
CADC_H ADC_H 0 7p
IADC_H 0 ADC_H 1u

.step param RX list 100 220 470 1k 2.2k 3k 3.16227766k 3.3k 4.7k 10k 22k 30k 31.6227766k 33k 47k 100k 220k 470k 1Meg
.temp 25
.tran 0 200u 0 200n
.save V(RC_SENSE) V(SENSE_IN) V(ADC) V(ADC_L) V(ADC_H)

.meas TRAN SELECTED_RREF PARAM RSEL
.meas TRAN VADC FIND V(ADC) AT=200u
.meas TRAN RX_EST PARAM RPATH*V(ADC)/(3.3-V(ADC))
.meas TRAN ERR_N_PCT PARAM 100*(RPATH*V(ADC)/(3.3-V(ADC))-RX)/RX
.meas TRAN ERR_LOW_PCT PARAM 100*(RPATH*(V(ADC_L)-EADC)/(3.3-(V(ADC_L)-EADC))-RX)/RX
.meas TRAN ERR_HIGH_PCT PARAM 100*(RPATH*(V(ADC_H)+EADC)/(3.3-(V(ADC_H)+EADC))-RX)/RX
.end
