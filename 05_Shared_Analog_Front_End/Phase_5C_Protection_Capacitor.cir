* SECDB Phase 5C - protected capacitor timing check.
* Adds TPD4E1B06 maximum line capacitance/leakage, 1 kohm sense-branch
* protection, a calibrated 330 ohm R/C socket guard, and the proposed
* 1 nF ADC filter to the Phase 5B path.

.include OPA391_TI_Model\OPAx391.LIB

.param CX=100n
.param RCH=10.01k
.param RDIS=1.001k
.param RON_SRC=9.5
.param RON_SENSE=9.5
.param RPROT=1k
.param RGUARD=330
.param RCHPATH=RCH+RON_SRC+RGUARD
.param RDISPATH=RDIS+RON_SRC+RGUARD
.param CPAR=100.95p
.param VTH=3.3*2589/4095
.param KTH=-ln(1-2589/4095)

VCC VCC 0 3.3
VCHARGE CHARGE_SRC 0 PULSE(0 3.3 1u 1n 1n 10s 20s)
RCHARGE CHARGE_SRC CH_SW {RCH}
RSRC_CH CH_SW RCI_CH {RON_SRC}
RGUARD_CH RCI_CH RC_CH {RGUARD}
CUNKNOWN_CH RC_CH 0 {CX}
CPAR_CH RC_CH 0 {CPAR}

* TPD leakage is at the exposed socket; mux leakage is after branch isolation.
IESD_CH RC_CH 0 0.5n
RPROT_CH RC_CH PROT_CH {RPROT}
RSENSE_CH PROT_CH SIN_CH {RON_SENSE}
IMUX_CH SIN_CH 0 2n
XUCH SIN_CH OUT_CH VCC 0 OUT_CH OPAx391
RISO_CH OUT_CH ADC_CH 100
CADC_CH ADC_CH 0 1n

* Discharge path. Sense branch does not carry discharge current.
VDIS DIS_SRC 0 PULSE(3.3 0 1u 1n 1n 10s 20s)
RDISCH DIS_SRC DIS_SW {RDIS}
RSRC_DIS DIS_SW RCI_DIS {RON_SRC}
RGUARD_DIS RCI_DIS RC_DIS {RGUARD}
CUNKNOWN_DIS RC_DIS 0 {CX}
CPAR_DIS RC_DIS 0 {CPAR}
IESD_DIS RC_DIS 0 0.5n

.step param CX list 100n 1u 10u 100u
.temp 25
.options plotwinsize=0 reltol=1e-6
.tran 0 {1u+2.2*RCHPATH*(CX+CPAR)} 0 {10*CX}
.save V(CHARGE_SRC) V(RC_CH) V(ADC_CH) V(DIS_SRC) V(RC_DIS)

.meas TRAN T63 TRIG V(CHARGE_SRC) VAL=1.65 RISE=1 TARG V(ADC_CH) VAL={VTH} RISE=1
.meas TRAN C_EST PARAM T63/(RCHPATH*KTH)
.meas TRAN C_ERR_PCT PARAM 100*(T63/(RCHPATH*KTH)-CX)/CX
.meas TRAN TDIS_1PCT TRIG V(DIS_SRC) VAL=1.65 FALL=1 TARG V(RC_DIS) VAL=33m FALL=1
.end
