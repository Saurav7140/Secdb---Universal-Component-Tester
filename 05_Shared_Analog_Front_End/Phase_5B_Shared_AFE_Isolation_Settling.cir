* SECDB Phase 5B - shared TMUX1108 isolation and worst-node settling checks

.include OPA391_TI_Model\OPAx391.LIB
.lib C:\Users\Saurav\AppData\Local\LTspice\lib\cmp\standard.dio
.lib C:\Users\Saurav\AppData\Local\LTspice\lib\cmp\standard.bjt

VCC VCC 0 3.3

* Calibration-channel transition from 1.1 V to 2.2 V.
VCAL CAL_SRC 0 PULSE(1.1 2.2 1u 1n 1n 1s 2s)
RS_CAL CAL_SRC CAL_IN 9.5
CS_CAL CAL_IN 0 100p
* Defined rail-level inactive channels through very high off resistance.
ROFF_C0 0 CAL_IN 1T
ROFF_C1 VCC CAL_IN 1T
ROFF_C2 1V1 CAL_IN 1T
ROFF_C3 2V2 CAL_IN 1T
V1V1 1V1 0 1.1
V2V2 2V2 0 2.2
IMUX_CAL CAL_IN 0 2n
XUCAL CAL_IN CAL_OUT VCC 0 CAL_OUT OPAx391
RISO_CAL CAL_OUT ADC_CAL 100
CADC_CAL ADC_CAL 0 7p

* Worst resistor-source settling: 100k reference and 1M DUT with 100p node load.
VRSTEP R_SRC 0 PULSE(0 3.3 1u 1n 1n 1s 2s)
RRPATH R_SRC R_NODE 100.1095k
RRX R_NODE 0 1Meg
CRNODE R_NODE 0 100p
RS_R R_NODE R_IN 9.5
XUR R_IN R_OUT VCC 0 R_OUT OPAx391
RISO_R R_OUT ADC_R 100
CADC_R ADC_R 0 7p

* BJT base-channel charge-sharing/recovery after the mux previously held 2.2 V.
RBE E_B 0 150
RBB VCC B_B 1.00105Meg
RBC VCC C_B 1.051k
QB C_B B_B E_B 2N3904

RRE E_REF 0 150
RRB VCC B_REF 1.00105Meg
RRC VCC C_REF 1.051k
QREF C_REF B_REF E_REF 2N3904

VPCTRL PRE_CTRL 0 PULSE(1 0 1u 1n 1n 1s 2s)
VBCTRL BASE_CTRL 0 PULSE(0 1 1.01u 1n 1n 1s 2s)
SPRE 2V2 B_IN PRE_CTRL 0 SWMUX
SBASE B_B B_IN BASE_CTRL 0 SWMUX
CBIN B_IN 0 100p
XUB B_IN B_OUT VCC 0 B_OUT OPAx391
RISO_B B_OUT ADC_B 100
CADC_B ADC_B 0 7p
BBASE_ERR BASE_ERR 0 V=abs(V(ADC_B)-V(B_REF))
BBASE_DIST BASE_DIST 0 V=abs(V(B_B)-V(B_REF))
.model SWMUX SW(Ron=9.5 Roff=1G Vt=0.5 Vh=0)

* Rail-level classification references use deterministic behavioral readback.
RREV_A 0 REV_A 1.051k
DREV REV_A REV_B 1N4148
RREV_B REV_B VCC 1.051k
BREV_A ADC_REV_A 0 V=V(REV_A)
BREV_B ADC_REV_B 0 V=V(REV_B)

ROPEN_A VCC OPEN_A 1.051k
ROPEN_DUT OPEN_A OPEN_B 1G
ROPEN_B OPEN_B 0 1.051k
BOPEN_A ADC_OPEN_A 0 V=V(OPEN_A)
BOPEN_B ADC_OPEN_B 0 V=V(OPEN_B)

RSHORT_A VCC SHORT_A 1.051k
RSHORT_DUT SHORT_A SHORT_B 10m
RSHORT_B SHORT_B 0 1.051k
BSHORT_A ADC_SHORT_A 0 V=V(SHORT_A)
BSHORT_B ADC_SHORT_B 0 V=V(SHORT_B)

.temp 25
.options plotwinsize=0 reltol=1e-6
.tran 0 1m 0 100n
.save V(CAL_SRC) V(ADC_CAL) V(R_SRC) V(ADC_R) V(BASE_CTRL) V(B_REF) V(B_B) V(ADC_B) V(BASE_ERR) V(BASE_DIST) V(ADC_REV_A) V(ADC_REV_B) V(ADC_OPEN_A) V(ADC_OPEN_B) V(ADC_SHORT_A) V(ADC_SHORT_B) I(RSHORT_A)

.param VRFINAL=3.3*1Meg/(1Meg+100.1095k)
.meas TRAN TCAL_1MV TRIG V(CAL_SRC) VAL=1.65 RISE=1 TARG V(ADC_CAL) VAL=2.199 RISE=1
.meas TRAN TRHIGH_1MV TRIG V(R_SRC) VAL=1.65 RISE=1 TARG V(ADC_R) VAL={VRFINAL-1m} RISE=1
.meas TRAN VR_FINAL FIND V(ADC_R) AT=1m
.meas TRAN BASE_MAX_DIST MAX V(BASE_DIST) FROM=1.01u TO=1m
.meas TRAN TBASE_NODE_1MV TRIG V(BASE_CTRL) VAL=0.5 RISE=1 TARG V(BASE_DIST) VAL=1m FALL=1
.meas TRAN BASE_DIST_50US FIND V(BASE_DIST) AT=50u
.meas TRAN BASE_DIST_100US FIND V(BASE_DIST) AT=100u
.meas TRAN BASE_DIST_200US FIND V(BASE_DIST) AT=200u
.meas TRAN BASE_ERR_100US FIND V(BASE_ERR) AT=100u
.meas TRAN VBASE_FINAL FIND V(ADC_B) AT=1m
.meas TRAN VREVERSE PARAM V(ADC_REV_B)-V(ADC_REV_A)
.meas TRAN VOPEN PARAM V(ADC_OPEN_A)-V(ADC_OPEN_B)
.meas TRAN VSHORT PARAM V(ADC_SHORT_A)-V(ADC_SHORT_B)
.meas TRAN ISHORT PARAM I(RSHORT_A)
.end
